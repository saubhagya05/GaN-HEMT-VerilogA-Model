* DC Sweep - 4x200 um Scaled Device

* 1. Load the OSDI library first
.control
pre_osdi gan_hemt.osdi
.endc

* 2. Define the model AND pass the 4x200 sizes
.model my_gan gan_hemt Ng=4 Wg=200e-6

* 3. Circuit Voltage
Vds d 0 dc 0
Vgs g 0 dc 0

* 4. Plug in the 3-node transistor
N1 d g 0 my_gan

* 5. Simulation Instructions (Batch Mode)
.control
dc Vds 0 40 0.5 Vgs -4 0 0.25

* Bypass the GUI and save an image file directly
set hcopydevtype=svg
hardcopy graph_4x200.svg -i(Vds) title '4x200um GaN HEMT: Ids vs Vds'

* Save the raw text data
wrdata dc_4x200_results.txt -i(Vds)

quit
.endc
.end
